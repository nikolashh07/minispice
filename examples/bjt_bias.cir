* Common-emitter voltage-divider bias (textbook style)
* Approximate hand analysis: VB = 22 × 3.9k/(39k + 3.9k) = 2.0 V, VE = VB - 0.7 = 1.3 V,
* IC ≈ IE = 1.3 V / 1.5k = 0.867 mA, VCE = 22 - 0.867 mA × (10k + 1.5k) = 12.0 V
* expect: v(b) = 2.0 tol=3%
* expect: v(e) = 1.3 tol=3%
* expect: i(Q1) = 0.867m tol=3%
* expect: v(c,e) = 12.0 tol=3%
VCC vcc 0 22
R1 vcc b 39k
R2 b 0 3.9k
RC vcc c 10k
RE e 0 1.5k
Q1 c b e mynpn
.model mynpn NPN(BF=140 IS=1e-14)
.op
