* Voltage-controlled current source: gm = 0.01 S, 1 V of control, 1k load
* I = 0.01 × 1 V = 10 mA into the load, so V = 10 mA × 1k = 10 V
* expect: v(out) = 10
* expect: i(RL) = 10m
V1 c 0 1
G1 0 out c 0 0.01
RL out 0 1k
.op
