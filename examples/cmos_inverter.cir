* CMOS inverter with matched transistors: the output flips when the input crosses VDD/2
* expect: v(out) = 2.5
VDD vdd 0 5
VIN in 0 2.5
M1 out in 0 nmos
M2 out in vdd pmos
.op
.dc VIN 0 5 0.05
