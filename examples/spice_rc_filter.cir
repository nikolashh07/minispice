Second-order RC low-pass filter (SPICE netlist from another tool)
* A title on the first line, $ comments, continuation lines, a .control block and
* .print lines are all standard SPICE; MiniSpice reads them and skips what it doesn't need.
.subckt rcstage in out params: r=1k c=100n
R1 in out {r}
C1 out 0 {c}
.ends rcstage
VIN in 0 DC 0 AC 1  $ the input
X1 in mid rcstage r=1k c=100n
X2 mid out rcstage
+ r=10k c=10n
.ac dec 20 10 1meg
.print ac vdb(out)
.options reltol=1e-4
.control
run
plot vdb(out)
.endc
.end
