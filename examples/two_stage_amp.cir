* Two-stage BJT amplifier with coupling capacitors, for AC and transient analysis
VCC vcc 0 12
VIN in 0 DC 0 AC 1 SIN(0 10m 1k)
C1 in b1 10u
R1 vcc b1 47k
R2 b1 0 10k
RC1 vcc c1 4.7k
RE1 e1 0 1k
CE1 e1 0 100u
Q1 c1 b1 e1 2n3904
C2 c1 b2 10u
R3 vcc b2 47k
R4 b2 0 10k
RC2 vcc out 4.7k
RE2 e2 0 1k
CE2 e2 0 100u
Q2 out b2 e2 2n3904
.ac dec 10 10 10meg
